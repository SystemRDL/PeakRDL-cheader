
addrmap child_addr_map_type_a {
    reg {
        default sw = rw;
        default hw = r;
        field {} basicfield_a[31:0];
    } basicreg_a;
};

addrmap child_addr_map_type_b {
    reg {
        default sw = rw;
        default hw = r;
        field {} basicfield_a[15:0];
    } basicreg_a;
};

addrmap child_addr_map_type_c {

    child_addr_map_type_b child_c_b;

    reg {
        default sw = rw;
        default hw = r;
        field {} basicfield_a[15:0];
    } basicreg_c;
};

addrmap addr_map {

    child_addr_map_type_a child_a;
    child_addr_map_type_a child_b[2];
    child_addr_map_type_b child_c;
};
