addrmap foo #(
    longint unsigned bar = 3,
    longint neg = -1,
    boolean enable = true,
    string name = "hello"
) {
    reg reg_t {
        field {sw=rw; hw=r;} f[7:0] = 1;
    };
    reg_t regs[bar];
};
